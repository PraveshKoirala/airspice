* Generated by AIR
.options filetype=ascii
.model NMOS NMOS(Vto=1.5 Kp=1)
.model PMOS PMOS(Vto=-1.5 Kp=1)
.model NPN NPN(Bf=100)
.model PNP PNP(Bf=100)
.model D D
I_LOAD_STEP 2 0 PULSE(1mA 100mA 2ms 5us 5us 1s 2s)
I_U_LDO_iq 1 0 DC 15uA
E_U_LDO 2 0 VALUE = { min(3.3V, V(1) - 0.25V) }
V_V_IN 1 0 DC 5V
.tran 1u 10ms
.control
run
wrdata ../waveforms/transient_2.csv v(2)
.endc
.end
