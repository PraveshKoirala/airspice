* Generated by AIR
.options filetype=ascii
.model NMOS NMOS(Vto=1.5 Kp=1)
.model PMOS PMOS(Vto=-1.5 Kp=1)
.model NPN NPN(Bf=100)
.model PNP PNP(Bf=100)
.model D D
V_3 3 0 DC 3.3V
D_D1 4 0 D
M_M1 4 3 1 1 PMOS
Q_Q1 4 2 0 NPN
R_R_B 3 2 1k
R_R_C 1 4 2.2k
V_V1 1 0 DC 5V
.tran 1u 2ms
.control
run
wrdata ../waveforms/switch_probe_4.csv v(4)
.endc
.end
