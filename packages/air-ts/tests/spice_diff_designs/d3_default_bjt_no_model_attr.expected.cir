* Generated by AIR
.options filetype=ascii
.model NMOS NMOS(Vto=1.5 Kp=1)
.model PMOS PMOS(Vto=-1.5 Kp=1)
.model NPN NPN(Bf=100)
.model PNP PNP(Bf=100)
.model D D
V_3 3 0 DC 5V
D_D_DEFAULT 20 100 D
M_M_DEFAULT 100 3 0 0 NMOS
Q_Q_DEFAULT 20 3 0 NPN
R_R1 1 20 3.3k
V_V1 1 0 DC 9V
.tran 1u 1ms
.control
run
wrdata ../waveforms/probe_all_100.csv v(100)
wrdata ../waveforms/probe_all_20.csv v(20)
.endc
.end
