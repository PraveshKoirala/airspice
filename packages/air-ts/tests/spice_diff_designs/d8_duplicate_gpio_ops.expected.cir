* Generated by AIR
.options filetype=ascii
.model NMOS NMOS(Vto=1.5 Kp=1)
.model PMOS PMOS(Vto=-1.5 Kp=1)
.model NPN NPN(Bf=100)
.model PNP PNP(Bf=100)
.model D D
V_STIM_U_MCU_GPIO0 sig 0 PULSE(0 3.3 0 1us 1us 999us 10ms)
V_STIM_U_MCU_GPIO0 sig 0 PULSE(0 3.3 0 1us 1us 999us 10ms)
V_V_33 v33 0 DC 3.3V
.tran 1u 20ms
.control
run
wrdata ../waveforms/quirk_probe_sig.csv v(sig)
.endc
.end
