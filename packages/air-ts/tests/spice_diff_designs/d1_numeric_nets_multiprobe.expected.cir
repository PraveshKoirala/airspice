* Generated by AIR
.options filetype=ascii
.model NMOS NMOS(Vto=1.5 Kp=1)
.model PMOS PMOS(Vto=-1.5 Kp=1)
.model NPN NPN(Bf=100)
.model PNP PNP(Bf=100)
.model D D
C_C_FILT 10 0 100nF
R_R_BOT 10 0 2.2k
R_R_MID 2 10 4.7k
R_R_TOP 1 2 10k
V_V_SRC 1 0 DC 12V
.tran 1u 50ms
.control
run
wrdata ../waveforms/divider_probe_10.csv v(10)
wrdata ../waveforms/divider_probe_2.csv v(2)
.endc
.end
