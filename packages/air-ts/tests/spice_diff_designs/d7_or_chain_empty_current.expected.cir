* Generated by AIR
.options filetype=ascii
.model NMOS NMOS(Vto=1.5 Kp=1)
.model PMOS PMOS(Vto=-1.5 Kp=1)
.model NPN NPN(Bf=100)
.model PNP PNP(Bf=100)
.model D D
I_LOADA v33 0 DC 10mA
I_LOADB v33 0 DC 5mA
V_V_33 v33 0 DC 3.3V
.tran 1u 10ms
.control
run
wrdata ../waveforms/or_chain_v33.csv v(v33)
.endc
.end
