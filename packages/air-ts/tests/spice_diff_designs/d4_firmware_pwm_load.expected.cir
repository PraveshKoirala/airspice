* Generated by AIR
.options filetype=ascii
.model NMOS NMOS(Vto=1.5 Kp=1)
.model PMOS PMOS(Vto=-1.5 Kp=1)
.model NPN NPN(Bf=100)
.model PNP PNP(Bf=100)
.model D D
V_STIM_U_MCU_GPIO7 2 0 PULSE(0 3.3 0 1us 1us 11us 40us)
I_I_BIAS 1 3 DC 1mA
I_LOAD1 1 0 DC 50mA
R_R_GATE 2 0 100k
V_V_3V3 1 0 DC 3.3V
.tran 1u 4ms
.control
run
wrdata ../waveforms/pwm_probe_3.csv v(3)
.endc
.end
