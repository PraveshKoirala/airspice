* Generated by AIR
.options filetype=ascii
.model NMOS NMOS(Vto=1.5 Kp=1)
.model PMOS PMOS(Vto=-1.5 Kp=1)
.model NPN NPN(Bf=100)
.model PNP PNP(Bf=100)
.model D D
V_2 2 0 DC 1V
R_R_BIG 1 2 4.7Meg
R_R_SMALL 2 0 1k
V_V_RAIL 1 0 DC 5V
.tran 1u 30ms
.control
run
wrdata ../waveforms/collide_2.csv v(2)
.endc
.end
