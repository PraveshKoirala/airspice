* Generated by AIR
.options filetype=ascii
.model NMOS NMOS(Vto=1.5 Kp=1)
.model PMOS PMOS(Vto=-1.5 Kp=1)
.model NPN NPN(Bf=100)
.model PNP PNP(Bf=100)
.model D D
V_VIN vin 0 DC 5V
R_R_BOTTOM vout 0 10k
R_R_TOP vin vout 10k
.tran 1u 10ms
.control
run
wrdata ../waveforms/divider_nominal_vout.csv v(vout)
.endc
.end
