* Generated by AIR
.options filetype=ascii
.model NMOS NMOS(Vto=1.5 Kp=1)
.model PMOS PMOS(Vto=-1.5 Kp=1)
.model NPN NPN(Bf=100)
.model PNP PNP(Bf=100)
.model D D
.model 2N2222 NPN(IS=1E-14 VAF=100 BF=200 IKF=0.3 XTB=1.5 BR=3 CJC=8E-12 CJE=25E-12 TR=100E-9 TF=400E-12 ITF=1 VTF=2 XTF=3 RB=10 RC=.3 RE=.2 Vceo=30 Icrating=800m)
V_DRIVE drive 0 DC 5V
Q_Q1 coll base 0 2N2222
R_RB drive base 10k
R_RC vcc coll 1k
V_V1 vcc 0 DC 5V
.tran 1u 1ms
.control
run
wrdata ../waveforms/switch_on_coll.csv v(coll)
.endc
.end
