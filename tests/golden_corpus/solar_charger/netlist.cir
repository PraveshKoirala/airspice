* Generated by AIR
.options filetype=ascii
.model NMOS NMOS(Vto=1.5 Kp=1)
.model PMOS PMOS(Vto=-1.5 Kp=1)
.model NPN NPN(Bf=100)
.model PNP PNP(Bf=100)
.model D D
V_V_SOLAR v_solar 0 DC 5.5V
V_STIM_U_MCU_GPIO2 load_ctrl 0 PULSE(0 3.3 0 1u 1u 1ms 100ms)
D_D_SCHOTTKY v_solar v_bat 1N5819
I_L_SYSTEM v_bat load_low DC 150mA
M_Q_LOAD_SW load_low load_ctrl 0 0 2N7002
R_R_BAT_BOT bat_sense 0 1Meg
R_R_BAT_TOP v_bat bat_sense 1Meg
R_R_SOLAR_BOT solar_sense 0 470k
R_R_SOLAR_INTERNAL v_solar_raw v_solar 10
R_R_SOLAR_TOP v_solar solar_sense 1Meg
I_U_REG_iq v_bat 0 DC 100uA
E_U_REG v_logic 0 VALUE = { min(3.3V, V(v_bat) - 0.2V) }
V_V_BAT v_bat 0 DC 3.7V
V_V_SOLAR v_solar_raw 0 DC 5.5V
.tran 1u 200ms
.control
run
wrdata ../waveforms/charging_scenario_bat_sense.csv v(bat_sense)
wrdata ../waveforms/charging_scenario_solar_sense.csv v(solar_sense)
wrdata ../waveforms/charging_scenario_v_logic.csv v(v_logic)
.endc
.end
