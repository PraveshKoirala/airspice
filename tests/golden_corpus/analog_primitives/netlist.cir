* Generated by AIR
.options filetype=ascii
.model NMOS NMOS(Vto=1.5 Kp=1)
.model PMOS PMOS(Vto=-1.5 Kp=1)
.model NPN NPN(Bf=100)
.model PNP PNP(Bf=100)
.model D D
I_LOAD_A vin 0 PULSE(2mA 10mA 1ms 1us 1us 1s 2s)
R_R_BOTTOM mid 0 10k
R_R_TOP vin mid 10k
V_V_IN vin 0 DC 5V
.tran 1u 5ms
.control
run
wrdata ../waveforms/divider_with_load_mid.csv v(mid)
.endc
.end
