* Generated by AIR
.options filetype=ascii
.model NMOS NMOS(Vto=1.5 Kp=1)
.model PMOS PMOS(Vto=-1.5 Kp=1)
.model NPN NPN(Bf=100)
.model PNP PNP(Bf=100)
.model D D
V_BAT bat 0 DC 4.2V
C_C_BAT_SENSE battery_sense 0 100nF
R_R_BAT_BOTTOM battery_sense 0 330k
R_R_BAT_TOP bat battery_sense 1Meg
I_U_REG_iq bat 0 DC 10uA
E_U_REG 3v3 0 VALUE = { min(3.3V, V(bat) - 200mV) }
.tran 1u 500ms
.control
run
wrdata ../waveforms/battery_adc_nominal_battery_sense.csv v(battery_sense)
.endc
.end
