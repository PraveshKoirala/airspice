* Generated by AIR
.options filetype=ascii
.model NMOS NMOS(Vto=1.5 Kp=1)
.model PMOS PMOS(Vto=-1.5 Kp=1)
.model NPN NPN(Bf=100)
.model PNP PNP(Bf=100)
.model D D
V_BAT bat 0 DC 3.7V
C_C_BAT_SENSE bat_sense 0 100nF
R_R_BAT_BOTTOM bat_sense 0 330k
R_R_BAT_TOP bat bat_sense 1Meg
.tran 1u 10ms
.control
run
wrdata ../waveforms/battery_divider_nominal_bat_sense.csv v(bat_sense)
.endc
.end
