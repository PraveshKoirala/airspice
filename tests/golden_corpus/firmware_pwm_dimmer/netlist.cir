* Generated by AIR
.options filetype=ascii
.model NMOS NMOS(Vto=1.5 Kp=1)
.model PMOS PMOS(Vto=-1.5 Kp=1)
.model NPN NPN(Bf=100)
.model PNP PNP(Bf=100)
.model D D
V_PWM_RAW pwm_raw 0 DC 3.3V
C_C_FILTER led_dc 0 1uF
R_R_FILTER pwm_raw led_dc 1k
.tran 1u 10ms
.control
run
wrdata ../waveforms/filter_dc_level_led_dc.csv v(led_dc)
.endc
.end
