* Generated by AIR
.options filetype=ascii
.model NMOS NMOS(Vto=1.5 Kp=1)
.model PMOS PMOS(Vto=-1.5 Kp=1)
.model NPN NPN(Bf=100)
.model PNP PNP(Bf=100)
.model D D
V_V_BAT v_bat 0 DC 4.0V
V_STIM_U_MCU_GPIO1 radio_en 0 PULSE(0 3.3 0 1u 1u 50ms 500ms)
I_L_RADIO v_3v3 radio_high DC 400mA
M_Q_RADIO_GATE radio_high radio_en 0 0 BSS138
M_Q_SCL_SHIFT scl_3v3 v_1v8 scl_1v8 scl_1v8 BSS138
M_Q_SDA_SHIFT sda_3v3 v_1v8 sda_1v8 sda_1v8 BSS138
R_R_BAT_HI v_bat bat_sense 1Meg
R_R_BAT_LO bat_sense 0 470k
I_U_REG_1V8_iq v_3v3 0 DC 25uA
E_U_REG_1V8 v_1v8 0 VALUE = { min(1.8V, V(v_3v3) - 0.1V) }
I_U_REG_3V3_iq v_bat 0 DC 50uA
E_U_REG_3V3 v_3v3 0 VALUE = { min(3.3V, V(v_bat) - 0.15V) }
V_V_EXT v_ext 0 DC 12V
X_X_CHARGER v_ext v_bat 0 MCP73831
X_X_SENSOR v_1v8 sda_1v8 scl_1v8 0 BME280
.tran 1u 1s
.control
run
wrdata ../waveforms/gateway_nominal_bat_sense.csv v(bat_sense)
wrdata ../waveforms/gateway_nominal_v_1v8.csv v(v_1v8)
wrdata ../waveforms/gateway_nominal_v_3v3.csv v(v_3v3)
.endc
.end
