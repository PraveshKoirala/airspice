* Generated by AIR
.options filetype=ascii
.model NMOS NMOS(Vto=1.5 Kp=1)
.model PMOS PMOS(Vto=-1.5 Kp=1)
.model NPN NPN(Bf=100)
.model PNP PNP(Bf=100)
.model D D
V_LOAD_LOW load_low 0 DC 3.7V
V_STIM_U_MCU_GPIO2 gate_drive 0 PULSE(0 3.3 0 1u 1u 5ms 10ms)
I_L_LOAD v_bat load_low DC 100mA
M_Q_SWITCH load_low gate_drive 0 0 NMOS
V_V_3V3 3v3 0 DC 3.3V
V_V_BAT v_bat 0 DC 3.7V
.tran 1u 20ms
.control
run
wrdata ../waveforms/switch_test_load_low.csv v(load_low)
.endc
.end
