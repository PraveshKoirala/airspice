* Generated by AIR
.options filetype=ascii
.model NMOS NMOS(Vto=1.5 Kp=1)
.model PMOS PMOS(Vto=-1.5 Kp=1)
.model NPN NPN(Bf=100)
.model PNP PNP(Bf=100)
.model D D
V_STIM_U_MCU_GPIO2 ctrl 0 PULSE(0 3.3 0 1u 1u 1ms 100us)
C_C_FILTER v_out 0 10uF
I_L_LOAD v_out 0 DC 100mA
M_Q_SW v_in ctrl v_out v_out BSS138
V_V_IN v_in 0 DC 12V
.tran 1u 10ms
.control
run
wrdata ../waveforms/fast_regulation_v_out.csv v(v_out)
.endc
.end
