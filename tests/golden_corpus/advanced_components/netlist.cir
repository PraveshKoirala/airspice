* Generated by AIR
.options filetype=ascii
.model NMOS NMOS(Vto=1.5 Kp=1)
.model PMOS PMOS(Vto=-1.5 Kp=1)
.model NPN NPN(Bf=100)
.model PNP PNP(Bf=100)
.model D D
V_CTRL ctrl 0 DC 3.3V
D_D_PROT v_in v_prot D
M_Q_SW switched ctrl 0 0 MY_NMOS
I_U_REG_iq v_prot 0 DC 50uA
E_U_REG v_out 0 VALUE = { min(3.3V, V(v_prot) - 0.2V) }
V_V_SOURCE v_in 0 DC 5V
X_X_CUSTOM v_out 0 switched LM358
.tran 1u 1ms
.control
run
wrdata ../waveforms/basic_v_out.csv v(v_out)
.endc
.end
