* Generated by AIR
.options filetype=ascii
.model NMOS NMOS(Vto=1.5 Kp=1)
.model PMOS PMOS(Vto=-1.5 Kp=1)
.model NPN NPN(Bf=100)
.model PNP PNP(Bf=100)
.model D D
V_BAT bat 0 DC 3.0V
C_C_BAT bat 0 1000uF
M_Q_CHG v_in charge_ctrl bat bat NMOS
R_R_SENSE_BOT bat_sense 0 100k
R_R_SENSE_TOP bat bat_sense 100k
I_U_REG_iq v_in 0 DC 10uA
E_U_REG v_3v3 0 VALUE = { min(3.3V, V(v_in) - 0.2V) }
V_V_SUPPLY v_in 0 DC 5V
.tran 1u 1s
.control
run
wrdata ../waveforms/charge_cycle_bat.csv v(bat)
.endc
.end
