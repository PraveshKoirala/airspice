* Generated by AIR
.options filetype=ascii
.model NMOS NMOS(Vto=1.5 Kp=1)
.model PMOS PMOS(Vto=-1.5 Kp=1)
.model NPN NPN(Bf=100)
.model PNP PNP(Bf=100)
.model D D
V_3V3 3v3 0 DC 3.3V
C_C_SOIL soil_sense 0 100nF
R_R_SOIL_BOTTOM soil_sense 0 10k
R_R_SOIL_TOP 3v3 soil_sense 10k
.tran 1u 10ms
.control
run
wrdata ../waveforms/soil_divider_nominal_soil_sense.csv v(soil_sense)
.endc
.end
